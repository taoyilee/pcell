/* Intellectual Properties of RFVLSI LAB, NCTU, TAIWAN.
Intended for Internal Use Only, All Rights Reserved, 2012
*DO NOT DISCLOSE*
Author : Tao-Yi Lee
*/

load("~/Codes/rod65/inductor/simple/under.il")
load("~/Codes/rod65/inductor/simple/ind_under.il")
load("~/Codes/rod65/inductor/simple/ind_lturn.il")
load("~/Codes/rod65/inductor/simple/ind_turn.il")
load("~/Codes/rod65/inductor/simple/ind_nturn.il")
load("~/Codes/rod65/inductor/simple/ind.il")
load("~/Codes/rod65/inductor/ind.cdf")
;load("~/Codes/rod65/inductor/simple/ind_b.il")
