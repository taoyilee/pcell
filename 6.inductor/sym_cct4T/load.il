/* 	Intellectual Properties of RFVLSI LAB, NCTU, TAIWAN.
	Intended for Internal Use Only, All Rights Reserved, 2012
	*DO NOT DISCLOSE*
	Author : Tao-Yi Lee */
load("~/Codes/rod65/inductor/sym_cct4T/lead_pair.il")
load("~/Codes/rod65/inductor/sym_cct4T/sym_cct4T_t.il")
load("~/Codes/rod65/inductor/sym_cct4T/sym_cct4T.il")
load("~/Codes/rod65/inductor/sym_cct4T/sym_cct4T.cdf")
