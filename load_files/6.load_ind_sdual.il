strLibName="RFVLSI_N65";
load_path="~/pcell/6.inductor"
load(strcat(load_path "/ind_sdual.il"))
load(strcat(load_path "/ind_sdual.cdf"))
load(strcat(load_path "/ind_sdualpp.il"))
load(strcat(load_path "/ind_sdualpp.cdf"))
load(strcat(load_path "/ind_sdualss.il"))
load(strcat(load_path "/ind_sdualss.cdf"))
load(strcat(load_path "/ind_ssLpL.il"))
load(strcat(load_path "/ind_ssLpL.cdf"))
