/*  TYLEE PCELL
    Copyright (C) 2013  Tao-Yi Lee (tylee@ieee.org)

    This program is free software: you can redistribute it and/or modify
    it under the terms of the GNU General Public License as published by
    the Free Software Foundation, either version 3 of the License, or
    (at your option) any later version.

    This program is distributed in the hope that it will be useful,
    but WITHOUT ANY WARRANTY; without even the implied warranty of
    MERCHANTABILITY or FITNESS FOR A PARTICULAR PURPOSE.  See the
    GNU General Public License for more details.

    You should have received a copy of the GNU General Public License
    along with this program.  If not, see <http://www.gnu.org/licenses/>.
*/
load(strcat(load_path "/base_highk.il"))
load(strcat(load_path "/base_highk_ud.il"))
load(strcat(load_path "/base_xfm_cross.il"))
load(strcat(load_path "/base_xfm_highk_pri.il"))
load(strcat(load_path "/base_xfm_half.il"))
load(strcat(load_path "/base_xfm_halfud.il"))
load(strcat(load_path "/base_balun_half.il"))
load(strcat(load_path "/base_balun_halfud.il"))
load(strcat(load_path "/base_balun_pri.il"))
load(strcat(load_path "/base_balun_sec.il"))
load(strcat(load_path "/xfm_highk.il"))
load(strcat(load_path "/xfm_highk.cdf"))
load(strcat(load_path "/xfm_highk_ct.il"))
load(strcat(load_path "/xfm_highk_ct.cdf"))
load(strcat(load_path "/balun.il"))
load(strcat(load_path "/balun.cdf"))
load(strcat(load_path "/balun_ct.il"))
