strLibName="RFVLSI_N65";
load_path="~/pcell/7.xfm_balun"
load(strcat(load_path "/base_highk.il"))
load(strcat(load_path "/base_highk_ud.il"))
load(strcat(load_path "/base_xfm_cross.il"))
load(strcat(load_path "/base_xfm_highk_pri.il"))
load(strcat(load_path "/base_xfm_half.il"))
load(strcat(load_path "/base_xfm_halfud.il"))
load(strcat(load_path "/base_balun_half.il"))
load(strcat(load_path "/base_balun_halfud.il"))
load(strcat(load_path "/base_balun_pri.il"))
load(strcat(load_path "/base_balun_sec.il"))
load(strcat(load_path "/xfm_highk.il"))
load(strcat(load_path "/xfm_highk.cdf"))
load(strcat(load_path "/xfm_highk_ct.il"))
load(strcat(load_path "/xfm_highk_ct.cdf"))
load(strcat(load_path "/balun.il"))
load(strcat(load_path "/balun.cdf"))
load(strcat(load_path "/balun_ct.il"))
