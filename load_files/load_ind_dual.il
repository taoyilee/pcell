/*  TYLEE PCELL
    Copyright (C) 2013  Tao-Yi Lee (tylee@ieee.org)

    This program is free software: you can redistribute it and/or modify
    it under the terms of the GNU General Public License as published by
    the Free Software Foundation, either version 3 of the License, or
    (at your option) any later version.

    This program is distributed in the hope that it will be useful,
    but WITHOUT ANY WARRANTY; without even the implied warranty of
    MERCHANTABILITY or FITNESS FOR A PARTICULAR PURPOSE.  See the
    GNU General Public License for more details.

    You should have received a copy of the GNU General Public License
    along with this program.  If not, see <http://www.gnu.org/licenses/>.
*/
load(strcat(load_path "/ind_dual.il"))
load(strcat(load_path "/ind_dual.cdf"))
load(strcat(load_path "/ind_duals.il"))
load(strcat(load_path "/ind_duals.cdf"))
load(strcat(load_path "/ind_dualp.il"))
load(strcat(load_path "/ind_dualp.cdf"))
load(strcat(load_path "/ind_dualpp.il"))
load(strcat(load_path "/ind_dualpp.cdf"))
load(strcat(load_path "/ind_dualss.il"))
load(strcat(load_path "/ind_dualss.cdf"))
load(strcat(load_path "/ind_sLpL.il"))
load(strcat(load_path "/ind_sLpL.cdf"))
