/*  TYLEE PCELL
    Copyright (C) 2013  Tao-Yi Lee (tylee@ieee.org)

    This program is free software: you can redistribute it and/or modify
    it under the terms of the GNU General Public License as published by
    the Free Software Foundation, either version 3 of the License, or
    (at your option) any later version.

    This program is distributed in the hope that it will be useful,
    but WITHOUT ANY WARRANTY; without even the implied warranty of
    MERCHANTABILITY or FITNESS FOR A PARTICULAR PURPOSE.  See the
    GNU General Public License for more details.

    You should have received a copy of the GNU General Public License
    along with this program.  If not, see <http://www.gnu.org/licenses/>.
*/
load(strcat(load_path "/ind_sdual.il"))
load(strcat(load_path "/ind_sdual.cdf"))
load(strcat(load_path "/ind_sdualpp.il"))
load(strcat(load_path "/ind_sdualpp.cdf"))
load(strcat(load_path "/ind_sdualss.il"))
load(strcat(load_path "/ind_sdualss.cdf"))
load(strcat(load_path "/ind_ssLpL.il"))
load(strcat(load_path "/ind_ssLpL.cdf"))
