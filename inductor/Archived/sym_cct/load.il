/* 	Intellectual Properties of RFVLSI LAB, NCTU, TAIWAN.
	Intended for Internal Use Only, All Rights Reserved, 2012
	*DO NOT DISCLOSE*
	Author : Tao-Yi Lee */
load("~/Codes/rod65/inductor/sym_cct/sym_cct_t.il")
load("~/Codes/rod65/inductor/sym_cct/sym_cct.il")
load("~/Codes/rod65/inductor/sym_cct/sym_cct.cdf")
