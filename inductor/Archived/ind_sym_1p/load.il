/* 	Intellectual Properties of RFVLSI LAB, NCTU, TAIWAN.
	Intended for Internal Use Only, All Rights Reserved, 2012
	*DO NOT DISCLOSE*
	Author : Tao-Yi Lee */

load("~/Codes/rod65/inductor/sym/ind_hud_cross.il")
load("~/Codes/rod65/inductor/sym/ind_sym.il")
load("~/Codes/rod65/inductor/ind_sym.cdf")
