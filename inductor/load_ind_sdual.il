/*  TYLEE PCELL
    Copyright (C) 2013  Tao-Yi Lee (tylee@ieee.org)

    This program is free software: you can redistribute it and/or modify
    it under the terms of the GNU General Public License as published by
    the Free Software Foundation, either version 3 of the License, or
    (at your option) any later version.

    This program is distributed in the hope that it will be useful,
    but WITHOUT ANY WARRANTY; without even the implied warranty of
    MERCHANTABILITY or FITNESS FOR A PARTICULAR PURPOSE.  See the
    GNU General Public License for more details.

    You should have received a copy of the GNU General Public License
    along with this program.  If not, see <http://www.gnu.org/licenses/>.
*/
load("vias.il")
load("mesh_rect.il")
load("base_em_gr.il")
load("base_em_bc.il")
load("base_lead.il")
load("base_lead_pair.il")
load("base_xfm_cross.il")
load("base_oct_quad.il")
load("base_oct_half.il")
load("base_oct.il")
load("base_oct_quad_fill.il")
load("base_oct_half_fill.il")
load("base_oct_fill.il")
load("base_ind_hud_cross.il")
load("ind_single.il")
load("base_ind_diag.il")
load("ind_sdual.il")
