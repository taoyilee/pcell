strLibName="RFVLSI_N65";
load_path="~/pcell/6.inductor"
load(strcat(load_path "/ind_dual.il"))
load(strcat(load_path "/ind_dual.cdf"))
load(strcat(load_path "/ind_duals.il"))
load(strcat(load_path "/ind_duals.cdf"))
load(strcat(load_path "/ind_dualp.il"))
load(strcat(load_path "/ind_dualp.cdf"))
load(strcat(load_path "/ind_dualpp.il"))
load(strcat(load_path "/ind_dualpp.cdf"))
load(strcat(load_path "/ind_dualss.il"))
load(strcat(load_path "/ind_dualss.cdf"))
load(strcat(load_path "/ind_sLpL.il"))
load(strcat(load_path "/ind_sLpL.cdf"))
