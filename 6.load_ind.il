strLibName="RFVLSI_N65";
load_path="~/pcell/6.inductor"
load(strcat(load_path "/base_ind_under.il"))
load(strcat(load_path "/base_ind_diag.il"))
load(strcat(load_path "/base_ind_turn.il"))
load(strcat(load_path "/base_ind_hud_cross.il"))
load(strcat(load_path "/ind_sym.il"))
load(strcat(load_path "/ind_sym.cdf"))
load(strcat(load_path "/ind_single.il"))
load(strcat(load_path "/ind_single.cdf"))
load(strcat(load_path "/ind_sym_ct.il"))
load(strcat(load_path "/ind_sym_ct.cdf"))
load(strcat(load_path "/ind_sym_cct2T.il"))
load(strcat(load_path "/ind_sym_cct2T.cdf"))
load(strcat(load_path "/ind_sym_cct4T.il"))
load(strcat(load_path "/ind_sym_cct4T.cdf"))
