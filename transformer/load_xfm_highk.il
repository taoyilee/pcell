/*  TYLEE PCELL
    Copyright (C) 2013  Tao-Yi Lee (tylee@ieee.org)

    This program is free software: you can redistribute it and/or modify
    it under the terms of the GNU General Public License as published by
    the Free Software Foundation, either version 3 of the License, or
    (at your option) any later version.

    This program is distributed in the hope that it will be useful,
    but WITHOUT ANY WARRANTY; without even the implied warranty of
    MERCHANTABILITY or FITNESS FOR A PARTICULAR PURPOSE.  See the
    GNU General Public License for more details.

    You should have received a copy of the GNU General Public License
    along with this program.  If not, see <http://www.gnu.org/licenses/>.
*/
load("vias.il")
load("vias_nomet.il")
load("vias_diagonal_nomet.il")
load("vias_diagonal.il")
load("base_ind_under.il")
load("base_em_bc.il")
load("base_em_gr.il")
load("vdiag_single.il")
load("vR45.il")
load("base_diagb.il")
load("base_diag.il")
load("X.il")
load("base_oct_quad_vias.il")
load("base_oct_half_vias.il")
load("base_oct_quad.il")
load("base_oct_half.il")
load("base_oct_quad_fill.il")
load("base_oct_half_fill.il")
load("base_oct.il")
load("base_ind_diag.il")
load("base_lead.il")
load("base_lead_pair.il")
load("base_balun_half.il")
load("base_balun_halfud.il")
load("base_xfm_cross.il")
load("base_xfm_highk_pri.il")
load("base_xfm_dmy.il")
load("base_xfm_body.il")
load("base_xfm_half.il")
load("base_highk_ud.il")
load("base_highk.il")
load("base_xfm_halfud.il")
load("base_balun_sec.il")
load("xfm_highk.il")
