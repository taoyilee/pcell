load("vias.il")
load("vias_nomet.il")
load("vias_diagonal_nomet.il")
load("vias_diagonal.il")
load("base_ind_under.il")
load("base_em_bc.il")
load("base_em_gr.il")
load("vdiag_single.il")
load("vR45.il")
load("base_diagb.il")
load("base_diag.il")
load("X.il")
load("base_oct_quad_vias.il")
load("base_oct_half_vias.il")
load("base_oct_quad.il")
load("base_oct_half.il")
load("base_oct_quad_fill.il")
load("base_oct_half_fill.il")
load("base_oct.il")
load("base_ind_diag.il")
load("base_lead.il")
load("base_lead_pair.il")
load("base_balun_half.il")
load("base_balun_halfud.il")
load("base_xfm_cross.il")
load("base_xfm_highk_pri.il")
load("base_xfm_dmy.il")
load("base_xfm_body.il")
load("base_xfm_half.il")
load("base_highk_ud.il")
load("base_highk.il")
load("base_xfm_halfud.il")
load("base_balun_sec.il")
load("xfm_highk.il")
