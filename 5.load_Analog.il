/* Intellectual Properties of RFVLSI LAB, NCTU, TAIWAN.
Intended for Internal Use Only, All Rights Reserved, 2012
*DO NOT DISCLOSE*
Author : Yu-Jiu Wang
*/

strLibName="RFVLSI_N65v1p1";
load_path="~/Codes/rod65v1p1/5.Analog"

load(strcat(load_path "/base_analog_DiffPair_Half.il"))
load(strcat(load_path "/base_analog_path_45thru.il"))
load(strcat(load_path "/base_analog_path_45thru_cross.il"))
load(strcat(load_path "/DiffActiveLoad.il"))
load(strcat(load_path "/DiffPair.il"))
load(strcat(load_path "/GilbertCell4T.il"))
load(strcat(load_path "/Switched_Mom_Cap.il"))
