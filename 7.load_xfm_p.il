strLibName="RFVLSI_N65";
load_path="~/pcell/7.xfm_balun"
load(strcat(load_path "/base_xfm_power.il"))
load(strcat(load_path "/xfm_power.il"))
load(strcat(load_path "/xfm_power.cdf"))
;load(strcat(load_path "/xfm_power_ct.il"))
;load(strcat(load_path "/xfm_power_ct.cdf"))
